** Profile: "SCHEMATIC1-sim1"  [ E:\ORCAD\workspace\cdssetup\workspace\projects\ktane_project\ktane_project-pspicefiles\schematic1\sim1.sim ]

** Creating circuit file "sim1.cir"
** WARNING: THIS AUTOMATICALLY GENERATED FILE MAY BE OVERWRITTEN BY SUBSEQUENT SIMULATIONS

*Libraries:
* Profile Libraries :
* Local Libraries :
* From [PSPICE NETLIST] section of E:\ORCAD\workspace\cdssetup\OrCAD_PSpice\24.1.0\PSpice.ini file:
.lib "nom.lib"

*Analysis directives:
.TRAN  0 10ms 0
.OPTIONS ADVCONV
.PROBE64 V(alias(*)) I(alias(*)) W(alias(*)) D(alias(*)) NOISE(alias(*))
.INC "..\SCHEMATIC1.net"

.END
